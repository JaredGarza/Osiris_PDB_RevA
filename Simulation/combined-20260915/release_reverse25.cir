* ============================================================================
* COMBINED PDB + OSIRIS Rev A -- reverse battery connection
* The XT60 is keyed, but a damaged/adapted connector or a miswired harness
* can still present reversed polarity. Q1's channel blocks the reverse path;
* D1 SMAJ24CA clamps. This checks that nothing downstream sees negative volts.
*   0 - 300ms   battery connected BACKWARDS at -14.8 V
* 300 - 900ms   corrected to +14.8 V -- does the board start normally after?
* ============================================================================
.lib C:\Users\jared\AppData\Local\LTspice\lib\sub\LTC4368-1.sub
.lib C:\Users\jared\AppData\Local\LTspice\lib\sub\LT3010.lib
.inc models\pdb_screen17_devices.lib
.inc ..\models\U21_SCREEN.lib
.lib C:\Users\jared\AppData\Local\LTspice\lib\sub\LTC4359.sub
.inc pdb\pdb_release.lib
.inc osiris\osiris_reva.lib

.param VREV=-25

VBAT VSRC 0 PWL(0 0 1m {VREV} 300m {VREV} 310m 14.8 900m 14.8)
RBATT VSRC VBIN 20m

XPDB VBIN PDBOUT PDB3V3 GP GF COMMON FAULTN ALERTN SCL SDA 0 PDB_CURRENT
LCBL PDBOUT NCBL 200n Rser=1m
RCBL NCBL   OSIN 6m
XOS  OSIN NAUX V5 V3 V5PROT VJET 0 OSIRIS_REVA
RAUX NAUX 0 1Meg

.tran 0 900m 0 20u
.options method=gear reltol=0.003

* --- During reverse connection -------------------------------------------
.meas TRAN REV_VBIN     MIN V(VBIN)   FROM 50m TO 295m
.meas TRAN REV_VOSIN    MIN V(OSIN)   FROM 50m TO 295m
.meas TRAN REV_PDBOUT   MIN V(PDBOUT) FROM 50m TO 295m
.meas TRAN REV_V5       MIN V(V5)     FROM 50m TO 295m
.meas TRAN REV_V3       MIN V(V3)     FROM 50m TO 295m
.meas TRAN REV_PDB3V3   MIN V(PDB3V3) FROM 50m TO 295m
.meas TRAN REV_IIN      MAX ABS(I(RBATT)) FROM 20m TO 295m
.meas TRAN REV_TVS_I2T  INTEG I(RBATT)*I(RBATT) FROM 1m TO 300m
.meas TRAN REV_GATE     MAX V(GF)-V(COMMON) FROM 50m TO 295m

* --- Recovery after polarity corrected -----------------------------------
.meas TRAN REC_VOSIN    AVG V(OSIN)   FROM 850m TO 895m
.meas TRAN REC_V5       AVG V(V5)     FROM 850m TO 895m
.meas TRAN REC_V3       AVG V(V3)     FROM 850m TO 895m
.meas TRAN REC_V5PROT   AVG V(V5PROT) FROM 850m TO 895m
.meas TRAN INP_MIN MIN V(XPDB:INA_IN_P)
.meas TRAN INN_MIN MIN V(XPDB:INA_IN_N)
.meas TRAN VBUS_MIN MIN V(XPDB:INA_VBUS)
.meas TRAN INP_MAX MAX V(XPDB:INA_IN_P)
.meas TRAN INN_MAX MAX V(XPDB:INA_IN_N)
.meas TRAN VBUS_MAX MAX V(XPDB:INA_VBUS)
.meas TRAN Q3_VDS MAX ABS(V(XPDB:VBAT_FUSED,XPDB:IDEAL_IN))
.meas TRAN Q3_VGS MAX ABS(V(XPDB:IDEAL_GATE,XPDB:IDEAL_IN))
.meas TRAN U5_IN_MIN MIN V(XPDB:IDEAL_IN,XPDB:IDEAL_VSS)
.meas TRAN U5_IN_MAX MAX V(XPDB:IDEAL_IN,XPDB:IDEAL_VSS)
.meas TRAN U5_OUT_MIN MIN V(XPDB:VBAT_FUSED,XPDB:IDEAL_VSS)
.meas TRAN U5_OUT_MAX MAX V(XPDB:VBAT_FUSED,XPDB:IDEAL_VSS)
.meas TRAN U5_GS_MIN MIN V(XPDB:IDEAL_GATE,XPDB:IDEAL_IN)
.meas TRAN U5_GS_MAX MAX V(XPDB:IDEAL_GATE,XPDB:IDEAL_IN)
.meas TRAN C11_STRESS MAX ABS(V(XPDB:VBAT_FUSED,XPDB:IDEAL_VSS))
.meas TRAN C16_STRESS MAX ABS(V(XPDB:INPUT_DAMP))
.meas TRAN INA_DIFF MAX ABS(V(XPDB:INA_IN_P,XPDB:INA_IN_N))
.save V(COMMON) V(GF) V(OSIN) V(PDB3V3) V(PDBOUT) V(V3) V(V5) V(V5PROT) V(VBIN) V(XPDB:IDEAL_GATE) V(XPDB:IDEAL_IN) V(XPDB:IDEAL_VSS) V(XPDB:INA_IN_N) V(XPDB:INA_IN_P) V(XPDB:INA_VBUS) V(XPDB:INPUT_DAMP) V(XPDB:VBAT_FUSED) I(RBATT)
.end
