* Model invariants: no phantom sinks and delayed boot load ramp.
.inc models\pdb_devices.lib
.inc ..\models\U21_SCREEN.lib
.inc osiris\osiris_reva.lib
XINA 0 0 0 DEAD 0 ALERT INA228_ANALOG
XBUF 0 Y DEAD 0 BUF_74AUP1G07
CDEAD DEAD 0 10u
RDEAD DEAD 0 1Meg
XLDO LDOIN LDOOUT 0 LDO_AMS1117
CLDO LDOIN 0 10u
RLDO LDOIN 0 1Meg
RLO LDOOUT 0 1k
VBUCK IN 0 PWL(0 12 100m 12 100.001m 0)
XBUCK IN BOUT IN 0 BUCK_AVG
VSENSE BOUT OUT 0
COUT OUT 0 100u
RLOAD OUT 0 10
VRAIL RAIL 0 PWL(0 0 200m 0 200.001m 5)
XDIG RAIL 0 DIGILOAD PARAMS: IBASE=1 TRAMP=20m
.tran 0 400m 0 10u
.options method=gear
.meas TRAN DEAD_MIN MIN V(DEAD) FROM 0 TO 400m
.meas TRAN LDO_MIN MIN V(LDOIN) FROM 0 TO 400m
.meas TRAN DISABLED_DELIVERY MAX I(VSENSE) FROM 101m TO 110m
.meas TRAN BOOT_EARLY MAX ABS(I(VRAIL)) FROM 200m TO 201m
.meas TRAN BOOT_LATE AVG ABS(I(VRAIL)) FROM 300m TO 390m
.end
