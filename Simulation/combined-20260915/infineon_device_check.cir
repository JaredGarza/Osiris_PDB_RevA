* Exact Infineon ISC015N06NM5LF2_L1 model at datasheet DC test conditions.
.lib "C:/Users/jared/Desktop/PCB/Kicad/Osiris_PDB_RevA/Simulation/vendor-models/infineon-60v/03_OptiMOS_OptiMOS5/OptiMOS_OptiMOS5_60V_LTSpice.lib"
.temp 25
VG G 0 10
I_TYP 0 D_TYP 50
I_MAX 0 D_MAX 50
X_TYP D_TYP G 0 ISC015N06NM5LF2_L1
X_MAX D_MAX G 0 ISC015N06NM5LF2_L1 PARAMS: dRdson=1
I_TH 0 VTH 120u
X_TH VTH VTH 0 ISC015N06NM5LF2_L1
.tran 0 100u 0 1u
.options solver=alt itl4=1000 reltol=0.0001
.meas TRAN RON_TYP AVG V(D_TYP)/50 FROM 50u TO 100u
.meas TRAN RON_MAX AVG V(D_MAX)/50 FROM 50u TO 100u
.meas TRAN VTH_TYP AVG V(VTH) FROM 50u TO 100u
.end
